ADE simulation setup
Test dc: project_working/LDO_1/schematic, simulator spectre
  Models: /home/work/PDKs/T-N65-CM-SP-007-K3_1_7A_MM/tsmcN65/../models/spectre/toplevel.scs[tt_lib]
  Variables: CK = 1p; CL = 0.5p; IOUT = 5m; R12 = 500; Rab = 40k; Rk = 500; VDD = 1.2
  Temperature: 27
  Operating points saved: /M0 (region); /M1 (region); /M2 (region); /M3 (region); /M4 (region); /M5 (region); /M6 (region); /M7 (region); /M8 (region)
  Analysis dc: sweep IOUT start=0 stop=5m (saves the operating point)
  Output v /Iout; dc (V) = v("/VOUT" ?result "dc")
  Output v /Vp; dc (V) = v("/Vp" ?result "dc") (unticked)
  Output OP("/M1" "vgs")
  Output OP("/M5" "vgs")
  Output OP("/M5" "region")
  Output VDC("/Vp")
  Output OP("/M6" "region")
  Output OP("/M0" "region")
  Output OP("/M1" "region")
  Output OP("/M2" "region")
  Output OP("/M3" "region")
  Output OP("/M4" "region")
  Output OP("/M2" "vds")
  Output OP("/M7" "region")
  Output OP("/M6" "vds")
  Output OP("/M8" "region")
  Output OP("/M0" "ids")
  Output OP("/M1" "ids")
  Output OP("/M2" "ids")
  Output OP("/M3" "ids")
  Output OP("/M4" "ids")
  Output OP("/M5" "ids")
  Output OP("/M6" "ids")
  Output OP("/M7" "ids")
  Output OP("/M8" "ids")
  Output OS("/M0" "region")
  Output OS("/M1" "region")
  Output OS("/M2" "region")
  Output OS("/M3" "region")
  Output OS("/M4" "region")
  Output OS("/M5" "region")
  Output OS("/M6" "region")
  Output OS("/M7" "region")
  Output OP("/M6" "vth")
  Output OS("/M8" "region")
  Output (OP("/M1" "gm") / OP("/M1" "ids"))
  Output (OP("/M2" "gm") / OP("/M2" "ids"))
  Output (OP("/M3" "gm") / OP("/M3" "ids"))
  Output (OP("/M4" "gm") / OP("/M4" "ids"))
  Output (OP("/M5" "gm") / OP("/M5" "ids"))
  Output (OP("/M6" "gm") / OP("/M6" "ids"))
  Output (OP("/M7" "gm") / OP("/M7" "ids"))
  Output (OP("/M8" "gm") / OP("/M8" "ids"))
  Output (OP("/M0" "gm") / OP("/M0" "ids"))
  Output OP("/M1" "vds")
  Output VDC("/VOUT")
  Output OP("/M5" "vds")
  Output OP("/M2" "vgs")
  Output OP("/M6" "vgs")
Test stb: project_working/LDO_1/schematic, simulator spectre
  Models: /home/work/PDKs/T-N65-CM-SP-007-K3_1_7A_MM/tsmcN65/../models/spectre/toplevel.scs[tt_lib]
  Variables: CK = 0.95p; CL = 0.5p; IOUT = 5m; R12 = 500; Rab = 40k; Rk = 500; VDD = 1.2
  Temperature: 27
  Analysis stb: start=1 stop=10G dec=10 probe=/IPRB0 stbProbeMode=differential
  Output Loop Gain Phase = phaseDegUnwrapped(getData("loopGain" ?result "stb"))
  Output Loop Gain dB20 = db(mag(getData("loopGain" ?result "stb")))
  Output PM = getData("phaseMargin" ?result "stb_margin")
  Output PM Freq = getData("phaseMarginFreq" ?result "stb_margin")
  Output GM = getData("gainMargin" ?result "stb_margin")
  Output GM Freq = getData("gainMarginFreq" ?result "stb_margin")
  Output value(db(mag(getData("loopGain" ?result "stb"))) 1)
Test noise: project_working/LDO_1/schematic, simulator spectre
  Models: /home/work/PDKs/T-N65-CM-SP-007-K3_1_7A_MM/tsmcN65/../models/spectre/toplevel.scs[tt_lib]
  Variables: CK = 1p; CL = 0.5p; IOUT = 5m; R12 = 500; Rab = 40k; Rk = 500; VDD = 1.2
  Temperature: 27
  Analysis dc: (saves the operating point)
  Analysis noise: start=1 stop=10G p=/VOUT n=/gnd! iprobe=/V6
  Output v = getData("out" ?result "noise")
  Output input noise; V / sqrt(Hz) = getData("in" ?result "noise") (unticked)
  Output value(getData("out" ?result "noise") 1000000)
Test PSRR: project_working/LDO_1/schematic, simulator spectre
  Models: /home/work/PDKs/T-N65-CM-SP-007-K3_1_7A_MM/tsmcN65/../models/spectre/toplevel.scs[tt_lib]
  Variables: CK = 1p; CL = 0.5p; IOUT = 5m; R12 = 500; Rab = 40k; Rk = 500; VDD = 1.2
  Temperature: 27
  Analysis xf: start=10 stop=10G p=/VOUT n=/gnd!
  Analysis dc: (saves the operating point)
  Output V/V /VDD; xf dB20(V/V) = db(getData("/VDD" ?result "xf"))
  Output dB20(value(getData("/VDD" ?result "xf") 10000000))
Test dc_points: project_working/LDO_1/schematic, simulator spectre
  Models: /home/work/PDKs/T-N65-CM-SP-007-K3_1_7A_MM/tsmcN65/../models/spectre/toplevel.scs[tt_lib]
  Variables: CK = 1p; CL = 0.5p; IOUT = 0 1m 2m 3m 4m 5m; R12 = 500; Rab = 40k; Rk = 500; VDD = 1.2
  Temperature: 27
  Analysis dc: (saves the operating point)
Test pz: project_working/LDO_1/schematic, simulator spectre
  Models: /home/work/PDKs/T-N65-CM-SP-007-K3_1_7A_MM/tsmcN65/../models/spectre/toplevel.scs[tt_lib]
  Variables: CK = 1p; CL = 0.5p; IOUT = 5m; R12 = 500; Rab = 40k; Rk = 500; VDD = 1.2
  Temperature: 27
  Analysis pz: p=/VOUT n=/gnd! iprobe=/VDD
  Output Poles = pzFrequencyAndRealFilter(getData("poles" ?result "pz"))
  Output Zeros = pzFrequencyAndRealFilter(getData("zeros" ?result "pz"))
