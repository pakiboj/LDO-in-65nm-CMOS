ADE simulation setup
Run mode: Single Run, Sweeps and Corners
Tests:
  dc: project_working/Testbench/schematic, simulator spectre
    Variables: IREF = 28.08u; CK = 1p; CL = 0.5p; IOUT = 5m; R12 = 500; Rab = 40k; Rk = 500; VDD = 1.2
    Outputs: VDC("/VOUT"); v /Iout; dc (V); OP("/M6" "vth"); OP("/M9" "ids"); OP("/M10" "ids")
  stb: project_working/Testbench/schematic, simulator spectre
    Variables: CK = 0.95p; CL = 0.5p; IOUT = 5m; R12 = 500; Rab = 40k; Rk = 500; VDD = 1.1
    Outputs: PM; GM; GM Freq
  noise: project_working/Testbench/schematic, simulator spectre
    Variables: IREF = 27u; CK = 1p; CL = 0.5p; IOUT = 5m; R12 = 500; Rab = 40k; Rk = 500; VDD = 1.2
  PSRR: project_working/Testbench/schematic, simulator spectre
    Variables: CK = 1p; CL = 0.5p; IOUT = 5m; R12 = 500; Rab = 40k; Rk = 500; VDD = 1.2
  important: LDO_210343d/Testbench_ideal/schematic, simulator spectre
    Variables: IREF = 28u; CK = 700f; CL = 0.5p; IOUT = 5m; R12 = 500; Rab = 40k; Rk = 500; VDD = 1.2
    Outputs: getData("gainMargin" ?result "stb_margin"); value(phaseDegUnwrapped(getData("/VDD" ?result "xf")) 1000000); V/V /VDD; xf deg(V/V); dB20(value(getData("/VDD" ?result "xf") 10000000)); nil; value(getData("out" ?result "noise") 1000000); OP("/I29/M9" "ids"); OP("/I29/M6" "ids"); OP("/I29/M1" "ids")
Device parameters:
  project_working/LDO_1_not_ideal/schematic/M9.l = 200n
  project_working/LDO_1_not_ideal/schematic/M9.wf = 50u
  project_working/LDO_1_not_ideal/schematic/M10.l = 200n
  project_working/LDO_1_not_ideal/schematic/M10.wf = 10u
  project_working/LDO_1_not_ideal/schematic/M0.l = 65.0n
  project_working/LDO_1_not_ideal/schematic/M0.wf = 130.055u
  project_working/LDO_1_not_ideal/schematic/M1.l = 130.0n
  project_working/LDO_1_not_ideal/schematic/M1.wf = 20u
  project_working/LDO_1_not_ideal/schematic/M2.l = M1/l@project_working/LDO_1_not_ideal/schematic
  project_working/LDO_1_not_ideal/schematic/M2.wf = M1/wf@project_working/LDO_1_not_ideal/schematic
  project_working/LDO_1_not_ideal/schematic/M3.l = M1/l@project_working/LDO_1_not_ideal/schematic
  project_working/LDO_1_not_ideal/schematic/M3.wf = M1/wf@project_working/LDO_1_not_ideal/schematic
  project_working/LDO_1_not_ideal/schematic/M4.l = M1/l@project_working/LDO_1_not_ideal/schematic
  project_working/LDO_1_not_ideal/schematic/M4.wf = M1/wf@project_working/LDO_1_not_ideal/schematic
  project_working/LDO_1_not_ideal/schematic/M5.l = M1/l@project_working/LDO_1_not_ideal/schematic
  project_working/LDO_1_not_ideal/schematic/M5.wf = M1/wf@project_working/LDO_1_not_ideal/schematic
  project_working/LDO_1_not_ideal/schematic/M6.l = M1/l@project_working/LDO_1_not_ideal/schematic
  project_working/LDO_1_not_ideal/schematic/M6.wf = M1/wf@project_working/LDO_1_not_ideal/schematic
  project_working/LDO_1_not_ideal/schematic/M7.l = M1/l@project_working/LDO_1_not_ideal/schematic
  project_working/LDO_1_not_ideal/schematic/M7.wf = M1/wf@project_working/LDO_1_not_ideal/schematic
  project_working/LDO_1_not_ideal/schematic/M8.l = M1/l@project_working/LDO_1_not_ideal/schematic
  project_working/LDO_1_not_ideal/schematic/M8.wf = M1/wf@project_working/LDO_1_not_ideal/schematic
Corners (all switched off):
  C0: temperature=-40, 27, 75; VDD=1.1, 1.2, 1.3
Specs:
  dc / v /Iout; dc (V): range 0.998 to 1.002
  stb / PM: < 75
  important / getData("phaseMargin" ?result "stb_margin"): < 75
  important / getData("gainMarginFreq" ?result "stb_margin"): > 3G
  important / getData("gainMargin" ?result "stb_margin"): > 20
  important / VDC("/VOUT"): range 0.990 to 1.010
  important / value(getData("out" ?result "noise") 1000000): < 50n
  important / dB20(value(getData("/VDD" ?result "xf") 10000000)): < -30
