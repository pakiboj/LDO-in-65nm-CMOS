ADE simulation setup
Run mode: Single Run, Sweeps and Corners
Tests:
  dc: project_working/LDO_1_ideal/schematic, simulator spectre
    Variables: CL = 0.5p; IOUT = 5m; R12 = 500; Rab = 40k; Rk = 500; VDD = 1.2; CK = 1p
    Outputs: VDC("/VOUT"); v /Iout; dc (V); OP("/M6" "vth")
  stb: project_working/LDO_1_ideal/schematic, simulator spectre
    Variables: CK = 0.95p; CL = 0.5p; IOUT = 5m; R12 = 500; Rab = 40k; Rk = 500; VDD = 1.1
    Outputs: PM; GM; GM Freq
  noise: project_working/LDO_1_ideal/schematic, simulator spectre
    Variables: CK = 1p; CL = 0.5p; IOUT = 5m; R12 = 500; Rab = 40k; Rk = 500; VDD = 1.2
  PSRR: project_working/LDO_1_ideal/schematic, simulator spectre
    Variables: CK = 1p; CL = 0.5p; IOUT = 5m; R12 = 500; Rab = 40k; Rk = 500; VDD = 1.2
  important: project_working/LDO_1_ideal/schematic, simulator spectre
    Variables: CK = 1p; CL = 0.5p; IOUT = 5m; R12 = 500; Rab = 40k; Rk = 500; VDD = 1.2
    Outputs: getData("gainMargin" ?result "stb_margin"); value(phaseDegUnwrapped(getData("/VDD" ?result "xf")) 1000000); V/V /VDD; xf deg(V/V); dB20(value(getData("/VDD" ?result "xf") 10000000))
Device parameters:
  project_working/LDO_1_ideal/schematic/M0.l = 65.0n
  project_working/LDO_1_ideal/schematic/M0.wf = 130u
  project_working/LDO_1_ideal/schematic/M1.l = 130n
  project_working/LDO_1_ideal/schematic/M1.wf = 20u
  project_working/LDO_1_ideal/schematic/M2.l = M1/l@project_working/LDO_1_ideal/schematic
  project_working/LDO_1_ideal/schematic/M2.wf = M1/wf@project_working/LDO_1_ideal/schematic
  project_working/LDO_1_ideal/schematic/M3.l = M1/l@project_working/LDO_1_ideal/schematic
  project_working/LDO_1_ideal/schematic/M3.wf = M1/wf@project_working/LDO_1_ideal/schematic
  project_working/LDO_1_ideal/schematic/M4.l = M1/l@project_working/LDO_1_ideal/schematic
  project_working/LDO_1_ideal/schematic/M4.wf = M1/wf@project_working/LDO_1_ideal/schematic
  project_working/LDO_1_ideal/schematic/M5.l = M1/l@project_working/LDO_1_ideal/schematic
  project_working/LDO_1_ideal/schematic/M5.wf = M1/wf@project_working/LDO_1_ideal/schematic
  project_working/LDO_1_ideal/schematic/M6.l = M1/l@project_working/LDO_1_ideal/schematic
  project_working/LDO_1_ideal/schematic/M6.wf = M1/wf@project_working/LDO_1_ideal/schematic
  project_working/LDO_1_ideal/schematic/M7.l = M1/l@project_working/LDO_1_ideal/schematic
  project_working/LDO_1_ideal/schematic/M7.wf = M1/wf@project_working/LDO_1_ideal/schematic
  project_working/LDO_1_ideal/schematic/M8.l = M1/l@project_working/LDO_1_ideal/schematic
  project_working/LDO_1_ideal/schematic/M8.wf = M1/wf@project_working/LDO_1_ideal/schematic
Corners (all switched off):
  C0: temperature=-40, 27, 75; VDD=1.1, 1.2, 1.3
Specs:
  dc / v /Iout; dc (V): range 0.998 to 1.002
  stb / PM: < 75
