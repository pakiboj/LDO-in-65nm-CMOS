ADE simulation setup
Test dc: project_working/LDO_1_ideal/schematic, simulator spectre
  Models: /home/work/PDKs/T-N65-CM-SP-007-K3_1_7A_MM/tsmcN65/../models/spectre/toplevel.scs[tt_lib]
  Variables: CK = 1p; CL = 0.5p; IOUT = 5m; R12 = 500; Rab = 40k; Rk = 500; VDD = 1.2
  Temperature: 27
  Operating points saved: /M0 (region); /M1 (region); /M2 (region); /M3 (region); /M4 (region); /M5 (region); /M6 (region); /M7 (region); /M8 (region)
  Analysis dc: sweep IOUT start=0 stop=5m (saves the operating point)
  Output v /Iout; dc (V) = v("/VOUT" ?result "dc")
  Output v /Vp; dc (V) = v("/Vp" ?result "dc") (unticked)
  Output (OP("/M7" "gm") / OP("/M7" "ids")) (unticked)
  Output (OP("/M8" "gm") / OP("/M8" "ids")) (unticked)
  Output OS("/M5" "region") (unticked)
  Output (OP("/M0" "gm") / OP("/M0" "ids")) (unticked)
  Output OP("/M2" "vds") (unticked)
  Output OP("/M1" "vds") (unticked)
  Output OS("/M0" "region") (unticked)
  Output VDC("/VOUT")
  Output OP("/M5" "vds") (unticked)
  Output OP("/M2" "vgs") (unticked)
  Output (OP("/M2" "gm") / OP("/M2" "ids")) (unticked)
  Output OP("/M6" "vgs") (unticked)
  Output OP("/M1" "vgs") (unticked)
  Output VDC("/Vp")
  Output OS("/M6" "region") (unticked)
  Output OP("/M6" "region")
  Output OP("/M0" "region")
  Output OP("/M1" "region")
  Output OP("/M2" "region")
  Output OP("/M3" "region")
  Output OP("/M7" "region")
  Output (OP("/M3" "gm") / OP("/M3" "ids")) (unticked)
  Output OP("/M6" "vds") (unticked)
  Output OP("/M8" "region")
  Output OP("/M0" "ids")
  Output OP("/M1" "ids")
  Output OP("/M2" "ids")
  Output OP("/M4" "ids")
  Output OP("/M5" "ids")
  Output OP("/M6" "ids")
  Output OP("/M7" "ids")
  Output OP("/M8" "ids")
  Output OS("/M1" "region") (unticked)
  Output OS("/M2" "region") (unticked)
  Output OS("/M3" "region") (unticked)
  Output OP("/M5" "vgs") (unticked)
  Output OS("/M4" "region") (unticked)
  Output OS("/M7" "region") (unticked)
  Output OP("/M6" "vth") (unticked)
  Output OS("/M8" "region") (unticked)
  Output OP("/M4" "region")
  Output (OP("/M1" "gm") / OP("/M1" "ids")) (unticked)
  Output (OP("/M4" "gm") / OP("/M4" "ids")) (unticked)
  Output OP("/M5" "region")
  Output (OP("/M5" "gm") / OP("/M5" "ids")) (unticked)
  Output OP("/M3" "ids")
  Output (OP("/M6" "gm") / OP("/M6" "ids")) (unticked)
Test stb: project_working/LDO_1_ideal/schematic, simulator spectre
  Models: /home/work/PDKs/T-N65-CM-SP-007-K3_1_7A_MM/tsmcN65/../models/spectre/toplevel.scs[tt_lib]
  Variables: CK = 0.95p; CL = 0.5p; IOUT = 5m; R12 = 500; Rab = 40k; Rk = 500; VDD = 1.1
  Temperature: 27
  Analysis stb: start=1 stop=10G dec=10 probe=/IPRB0 stbProbeMode=differential
  Output Loop Gain Phase = phaseDegUnwrapped(getData("loopGain" ?result "stb")) (unticked)
  Output Loop Gain dB20 = db(mag(getData("loopGain" ?result "stb"))) (unticked)
  Output PM = getData("phaseMargin" ?result "stb_margin")
  Output PM Freq = getData("phaseMarginFreq" ?result "stb_margin")
  Output GM = getData("gainMargin" ?result "stb_margin")
  Output GM Freq = getData("gainMarginFreq" ?result "stb_margin")
  Output value(db(mag(getData("loopGain" ?result "stb"))) 1)
Test noise: project_working/LDO_1_ideal/schematic, simulator spectre
  Models: /home/work/PDKs/T-N65-CM-SP-007-K3_1_7A_MM/tsmcN65/../models/spectre/toplevel.scs[tt_lib]
  Variables: CK = 1p; CL = 0.5p; IOUT = 5m; R12 = 500; Rab = 40k; Rk = 500; VDD = 1.2
  Temperature: 27
  Analysis dc: (saves the operating point)
  Analysis noise: start=1 stop=10G p=/VOUT n=/gnd! iprobe=/V6
  Output v = getData("out" ?result "noise")
  Output input noise; V / sqrt(Hz) = getData("in" ?result "noise") (unticked)
  Output value(getData("out" ?result "noise") 1000000)
Test PSRR: project_working/LDO_1_ideal/schematic, simulator spectre
  Models: /home/work/PDKs/T-N65-CM-SP-007-K3_1_7A_MM/tsmcN65/../models/spectre/toplevel.scs[tt_lib]
  Variables: CK = 1p; CL = 0.5p; IOUT = 5m; R12 = 500; Rab = 40k; Rk = 500; VDD = 1.2
  Temperature: 27
  Analysis dc: (saves the operating point)
  Analysis xf: start=10 stop=10G p=/VOUT n=/gnd!
  Output V/V /VDD; xf dB20(V/V) = db(getData("/VDD" ?result "xf"))
  Output dB20(value(getData("/VDD" ?result "xf") 10000000))
Test important: project_working/LDO_1_ideal/schematic, simulator spectre
  Models: /home/work/PDKs/T-N65-CM-SP-007-K3_1_7A_MM/tsmcN65/../models/spectre/toplevel.scs[tt_lib]
  Variables: CK = 1p; CL = 0.5p; IOUT = 5m; R12 = 500; Rab = 40k; Rk = 500; VDD = 1.2
  Temperature: 27
  Analysis stb: start=1 stop=10G probe=/IPRB0 stbProbeMode=differential
  Analysis xf: start=1 stop=10G dec=10 p=/VOUT n=/gnd!
  Analysis dc: sweep IOUT start=0 stop=5m (saves the operating point)
  Output getData("phaseMargin" ?result "stb_margin")
  Output getData("phaseMarginFreq" ?result "stb_margin")
  Output dB20(value(getData("/VDD" ?result "xf") 10000000))
  Output VDC("/VOUT")
  Output value("/VOUT " 0.001)
  Output getData("gainMarginFreq" ?result "stb_margin")
  Output getData("gainMargin" ?result "stb_margin")
  Output Loop Gain dB20 = db(mag(getData("loopGain" ?result "stb")))
  Output Loop Gain Phase = phaseDegUnwrapped(getData("loopGain" ?result "stb"))
  Output V/V /VDD; xf deg(V/V) = db(getData("/VDD" ?result "xf"))
  Signals: /VOUT
Run mode: Single Run, Sweeps and Corners
Device parameters:
  project_working/LDO_1_ideal/schematic/M0.l = 65.0n
  project_working/LDO_1_ideal/schematic/M0.wf = 130u
  project_working/LDO_1_ideal/schematic/M1.l = 130n
  project_working/LDO_1_ideal/schematic/M1.wf = 20u
  project_working/LDO_1_ideal/schematic/M2.l = M1/l@project_working/LDO_1_ideal/schematic
  project_working/LDO_1_ideal/schematic/M2.wf = M1/wf@project_working/LDO_1_ideal/schematic
  project_working/LDO_1_ideal/schematic/M3.l = M1/l@project_working/LDO_1_ideal/schematic
  project_working/LDO_1_ideal/schematic/M3.wf = M1/wf@project_working/LDO_1_ideal/schematic
  project_working/LDO_1_ideal/schematic/M4.l = M1/l@project_working/LDO_1_ideal/schematic
  project_working/LDO_1_ideal/schematic/M4.wf = M1/wf@project_working/LDO_1_ideal/schematic
  project_working/LDO_1_ideal/schematic/M5.l = M1/l@project_working/LDO_1_ideal/schematic
  project_working/LDO_1_ideal/schematic/M5.wf = M1/wf@project_working/LDO_1_ideal/schematic
  project_working/LDO_1_ideal/schematic/M6.l = M1/l@project_working/LDO_1_ideal/schematic
  project_working/LDO_1_ideal/schematic/M6.wf = M1/wf@project_working/LDO_1_ideal/schematic
  project_working/LDO_1_ideal/schematic/M7.l = M1/l@project_working/LDO_1_ideal/schematic
  project_working/LDO_1_ideal/schematic/M7.wf = M1/wf@project_working/LDO_1_ideal/schematic
  project_working/LDO_1_ideal/schematic/M8.l = M1/l@project_working/LDO_1_ideal/schematic
  project_working/LDO_1_ideal/schematic/M8.wf = M1/wf@project_working/LDO_1_ideal/schematic
Corners (all switched off):
  C0: temperature=-40, 27, 75; VDD=1.1, 1.2, 1.3
Specs:
  dc / v /Iout; dc (V): range 0.998 to 1.002
  stb / PM: < 75
